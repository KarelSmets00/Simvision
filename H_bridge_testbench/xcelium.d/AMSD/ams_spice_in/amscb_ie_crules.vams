//*** amscb_ie_crules.vams ***
//* connect rules file for AMSCB IE card
//* This file is automatically generated.

//* (c) Copyright 2007-2010 Cadence Design Systems, Inc.
//* All rights reserved.

`include "disciplines.vams"

// using connectrule: CR_full_fast
discipline ddiscrete_3_3
  domain discrete;
enddiscipline

`define vsup 3.3
`define tr 0.2n
`define rout 200
`define vss 0
`define vlo `vss
`define vhi `vsup+`vss
`define vthi `vlo+(`vhi-(`vlo))*2.0/3.0
`define vtlo `vlo+(`vhi-(`vlo))/3.0
`define vx `vlo
`define vtol (`vthi-(`vtlo))/4.0
`define tf `tr
`define txdel (`tr)*4.0
`define tdeltran 0
`define ttoltran (`tr)/10.0
`define ttolcross (`tr)/4.0
`define rlo `rout==0?200:`rout
`define rhi `rout==0?200:`rout
`define rx `rout==0?200:`rout
`define rz 10M
`define vdelta (`vsup)/64.0
`define vtoldelta (`vdelta)/4.0
`define ttoldelta (`tr)/20.0
`define vpso 0.2
`define rsupply 4
`define rpull 1.5e3
`define rlarge 9.0e3
`define rweak 5.5e4
`define rmedium 3.2e5
`define rsmall 1.9e6
`define vtrhi `vthi/`vsup
`define vtrlo `vtlo/`vsup
`define vrtol `vtol/`vsup
`define nox 0
`define currentmode 0
`define clamp 0
`define rin 200
`define idelta 10u
`define itoldelta (`idelta)/4.0
`define ix 0
`define vbias `vss+(`vsup)/2.0
`define dvclamp (`vsup)/20.0
`define enable_highz 0
`define duration 5.00E-09
`define Ts 1n
`define Ra 100
`define MaxIter 4
`define Vtol 1e-6
`define Itol 1e-10
`define Rrel 1e-4
`define Roff 1e12
`define Vx 0
`define Rx `Roff

connectrules ddiscrete_3_3_cr;
connect Bidir_2  #( .vsup(`vsup), .vthi(`vthi), .vtlo(`vtlo), .vlo(`vlo), .vhi(`vhi), .vx(`vx), .vtol(`vtol), .tr(`tr), .tf(`tf), .ttol_t(`ttoltran), .tdelay(`tdeltran), .txdel(`txdel), .ttol_c(`ttolcross), .rlo(`rlo), .rhi(`rhi), .rx(`rx), .rz(`rz), .nox(`nox), .r_SUPPLY(`rsupply), .r_PULL(`rpull), .r_LARGE(`rlarge), .r_WEAK(`rweak), .r_MEDIUM(`rmedium), .r_SMALL(`rsmall), .enable_highz(`enable_highz), .duration(`duration) )ddiscrete_3_3, electrical;
connect Bidir_2_LPS  #( .vsup(`vsup), .vthi(`vthi), .vtlo(`vtlo), .vlo(`vlo), .vhi(`vhi), .vx(`vx), .vtol(`vtol), .tr(`tr), .tf(`tf), .ttol_t(`ttoltran), .tdelay(`tdeltran), .txdel(`txdel), .ttol_c(`ttolcross), .rlo(`rlo), .rhi(`rhi), .rx(`rx), .rz(`rz), .vpso(`vpso), .vtrhi(`vtrhi), .vtrlo(`vtrlo), .vrtol(`vrtol), .r_SUPPLY(`rsupply), .r_PULL(`rpull), .r_LARGE(`rlarge), .r_WEAK(`rweak), .r_MEDIUM(`rmedium), .r_SMALL(`rsmall), .enable_highz(`enable_highz), .duration(`duration) )ddiscrete_3_3, electrical;
connect E2L_2  #( .vsup(`vsup), .vthi(`vthi), .vtlo(`vtlo), .vtol(`vtol), .tr(`tr), .txdel(`txdel), .ttol_c(`ttolcross), .nox(`nox), .enable_highz(`enable_highz), .duration(`duration) )ddiscrete_3_3, electrical;
connect E2L_2_LPS  #( .vsup(`vsup), .vthi(`vthi), .vtlo(`vtlo), .vtol(`vtol), .vtrhi(`vtrhi), .vtrlo(`vtrlo), .vrtol(`vrtol), .tr(`tr), .txdel(`txdel), .ttol_c(`ttolcross), .enable_highz(`enable_highz), .duration(`duration) )ddiscrete_3_3, electrical;
connect E2R  #( .vdelta(`vdelta), .vtol(`vtoldelta), .ttol(`ttoldelta), .vss(`vss), .vsup(`vsup), .currentmode(`currentmode), .idelta(`idelta), .itol(`itoldelta), .vbias(`vbias), .rin(`rin) )ddiscrete_3_3, electrical;
connect E2R_LPS  #( .vdelta(`vdelta), .vtol(`vtoldelta), .ttol(`ttoldelta), .currentmode(`currentmode) )ddiscrete_3_3, electrical;
connect EEnet_2_E  #( .Ts(`Ts), .Ra(`Ra), .MaxIter(`MaxIter), .Vtol(`Vtol), .Itol(`Itol), .Rrel(`Rrel), .Roff(`Roff), .Vx(`Vx), .Rx(`Rx))ddiscrete_3_3, electrical;
connect ER_Bidir_LPS  #( .vdelta(`vdelta), .vtol(`vtoldelta), .ttol(`ttoldelta), .tr(`ttoldelta), .tf(`ttoldelta), .tdelay(`tdeltran), .rout((`rout)==0?200:(`rout)), .rz(`rz), .vpso(`vpso), .currentmode(`currentmode) )ddiscrete_3_3, electrical;
connect ER_bidir  #( .vdelta(`vdelta), .vtol(`vtoldelta), .ttol(`ttoldelta), .tr(`ttoldelta), .tf(`ttoldelta), .tdelay(`tdeltran), .rout((`rout)==0?200:(`rout)), .rz(`rz), .vsup(`vsup), .currentmode(`currentmode), .idelta(`idelta), .itol(`itoldelta), .vbias(`vbias), .rin(`rin), .clamp(`clamp), .dvclamp(`dvclamp), .ix(`ix), .idealmode((`rout) == 0) )ddiscrete_3_3, electrical;
connect E_2_EEnet  #( .Ts(`Ts), .Ra(`Ra), .MaxIter(`MaxIter), .Vtol(`Vtol), .Itol(`Itol), .Rrel(`Rrel), .Roff(`Roff), .Vx(`Vx), .Rx(`Rx))ddiscrete_3_3, electrical;
connect E_EEnet_Bidir  #( .Ts(`Ts), .Ra(`Ra), .MaxIter(`MaxIter), .Vtol(`Vtol), .Itol(`Itol), .Rrel(`Rrel), .Roff(`Roff), .Vx(`Vx), .Rx(`Rx))ddiscrete_3_3, electrical;
connect L2E_2  #( .vsup(`vsup), .vlo(`vlo), .vthi(`vthi), .vtlo(`vtlo), .vhi(`vhi), .vx(`vx), .tr(`tr), .tf(`tf), .ttol_t(`ttoltran), .tdelay(`tdeltran), .rlo(`rlo), .rhi(`rhi), .rx(`rx), .rz(`rz), .r_SUPPLY(`rsupply), .r_PULL(`rpull), .r_LARGE(`rlarge), .r_WEAK(`rweak), .r_MEDIUM(`rmedium), .r_SMALL(`rsmall) )ddiscrete_3_3, electrical;
connect L2E_2_LPS  #( .vsup(`vsup), .vlo(`vlo), .vthi(`vthi), .vtlo(`vtlo), .vhi(`vhi), .vx(`vx), .tr(`tr), .tf(`tf), .ttol_t(`ttoltran), .tdelay(`tdeltran), .rlo(`rlo), .rhi(`rhi), .rx(`rx), .rz(`rz), .vpso(`vpso), .r_SUPPLY(`rsupply), .r_PULL(`rpull), .r_LARGE(`rlarge), .r_WEAK(`rweak), .r_MEDIUM(`rmedium), .r_SMALL(`rsmall) )ddiscrete_3_3, electrical;
connect L2R  #( .vsup(`vsup), .vlo(`vlo), .vhi(`vhi) )ddiscrete_3_3, ddiscrete_3_3;
connect L2R_LPS  #( .vsup(`vsup), .vlo(`vlo), .vhi(`vhi) )ddiscrete_3_3, ddiscrete_3_3;
connect R2E_2  #( .vsup(`vsup), .vdelta(`vdelta), .vss(`vss), .vx(`vx), .tr(`ttoldelta), .tf(`ttoldelta), .tdelay(`tdeltran), .rout((`rout)==0?200:(`rout)), .rx(`rx), .rz(`rz), .currentmode(`currentmode), .idelta(`idelta), .clamp(`clamp), .dvclamp(`dvclamp), .ix(`ix), .idealmode((`rout) == 0) )ddiscrete_3_3, electrical;
connect R2E_2_LPS  #( .vsup(`vsup), .vdelta(`vdelta), .vlo(`vlo), .vx(`vx), .tr(`ttoldelta), .tf(`ttoldelta), .tdelay(`tdeltran), .rout((`rout)==0?200:(`rout)), .rx(`rx), .rz(`rz), .vpso(`vpso), .currentmode(`currentmode) )ddiscrete_3_3, electrical;
connect R2L  #( .vsup(`vsup), .vlo(`vlo), .vhi(`vhi), .vtlo(`vtlo), .vthi(`vthi) )ddiscrete_3_3, ddiscrete_3_3;
connect R2L_LPS  #( .vsup(`vsup), .vlo(`vlo), .vhi(`vhi), .vtlo(`vtlo), .vthi(`vthi), .vtrhi(`vtrhi), .vtrlo(`vtrlo))ddiscrete_3_3, ddiscrete_3_3;
connect RL_Bidir_LPS  #( .vsup(`vsup), .vlo(`vlo), .vhi(`vhi), .vtlo(`vtlo), .vthi(`vthi), .vtrhi(`vtrhi), .vtrlo(`vtrlo))ddiscrete_3_3, ddiscrete_3_3;
connect RL_bidir  #( .vsup(`vsup), .vlo(`vlo), .vhi(`vhi), .vtlo(`vtlo), .vthi(`vthi) )ddiscrete_3_3, ddiscrete_3_3;
endconnectrules
